* board_05 Q1 WITH THE CORRECT LOW-SIDE WIRING (for comparison)
*   Q1 pin3 (collector) -> RELAY_COIL_NEG -> relay coil -> VCC_5V
*   Q1 pin1 (emitter)   -> GND
* Everything else identical to q1_as_built.cir

VMCU  5  0  DC 5
RBASE MCU  B  1k
RL    5  C  70            * relay coil from +5V to the collector node
D1    C  5  1N4007        * flyback: anode at coil low side, cathode at +5V
Q1    C  B  0  2N2222A    * correct: collector -> coil, emitter -> GND

.model 2N2222A NPN(IS=1.0E-14 BF=250 BR=6 IKF=0.15 IKR=0.03 ISE=2.0E-14 ISC=1.0E-13
+ NE=1.4 NC=1.2 RB=10 RC=1 RE=0 CJE=22p TF=0.4n TR=50n CJC=7p VJE=0.75 VJC=0.75
+ MJE=0.33 MJC=0.33 VAF=100 VAR=25 XTB=1.5 XTI=3)
.model 1N4007 D(IS=1.0E-9 N=1.6 RS=0.05 CJO=25p)

.control
op
print v(b) v(c) v(e) i(vMCU) i(rl)
.endc
.end
